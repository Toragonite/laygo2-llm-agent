* nand3_2x : LVS reference netlist for the golden layout ref/golden/nand3.py (nf=2)
* Topology from `.subckt nand_3in A B C Y VDD VSS` in
*   third_party/laygo2_workspace_sky130/lvs_example/dec_2to4.spice
* Changes vs. that netlist (so it matches what the layout actually draws):
*   - subckt name nand3_2x (pins A B C Y VDD VSS unchanged, same as the layout pin labels)
*   - W from the templates, not the schematic: nfet W=0.5, pfet W=1.0 per finger (L=0.15);
*     nf=2 gives 2 fingers -> m=2 (lvs_example had W=1.2 / 2.4)
*   - ad/as/pd/ps/nrd/nrs/sa/sb/sd dropped
.subckt nand3_2x A B C Y VDD VSS
XMN2 Y A net1 VSS sky130_fd_pr__nfet_01v8_lvt L=0.15 W=0.5 nf=1 m=2
XMN1 net1 B net2 VSS sky130_fd_pr__nfet_01v8_lvt L=0.15 W=0.5 nf=1 m=2
XMN0 net2 C VSS VSS sky130_fd_pr__nfet_01v8_lvt L=0.15 W=0.5 nf=1 m=2
XMP2 Y A VDD VDD sky130_fd_pr__pfet_01v8 L=0.15 W=1.0 nf=1 m=2
XMP1 Y B VDD VDD sky130_fd_pr__pfet_01v8 L=0.15 W=1.0 nf=1 m=2
XMP0 Y C VDD VDD sky130_fd_pr__pfet_01v8 L=0.15 W=1.0 nf=1 m=2
.ends
.end
